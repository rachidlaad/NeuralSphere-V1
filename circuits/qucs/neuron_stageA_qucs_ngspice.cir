* Qucs 26.1.1  C:/Users/intel/AppData/Local/Temp/ns_qucs_7yad30mc/neuron_stageA.sch
.INCLUDE "C:/Users/intel/Documents/NeuralSphere-V1/tools/qucs-s/share/qucs-s/xspice_cmlib/include/ngspice_mathfunc.inc"
VIN0 in0 0 DC 1
RP0 _net0 in0  19802 tc1=0.0 tc2=0.0
RN0 _net1 in0  1E+06 tc1=0.0 tc2=0.0
VIN1 in1 0 DC 0.5
RP1 _net0 in1  1E+06 tc1=0.0 tc2=0.0
RN1 _net1 in1  38835 tc1=0.0 tc2=0.0
VIN2 in2 0 DC 0.25
RP2 _net0 in2  74766.4 tc1=0.0 tc2=0.0
RN2 _net1 in2  1E+06 tc1=0.0 tc2=0.0
VIN3 in3 0 DC 1
RP3 _net0 in3  1E+06 tc1=0.0 tc2=0.0
RN3 _net1 in3  10000 tc1=0.0 tc2=0.0
VBIAS bias 0 DC 1
RP4 _net0 bias  63091.5 tc1=0.0 tc2=0.0
RN4 _net1 bias  1E+06 tc1=0.0 tc2=0.0
B_OPP tp 0 V = 1E6*V(0,_net0)*u(5-1E6*V(0,_net0))*u(1E6*V(0,_net0)-(-5))+5*u(1E6*V(0,_net0)-5)+(-5)*u((-5)-1E6*V(0,_net0))
RFP _net0 tp  10000 tc1=0.0 tc2=0.0
B_OPN tn 0 V = 1E6*V(0,_net1)*u(5-1E6*V(0,_net1))*u(1E6*V(0,_net1)-(-5))+5*u(1E6*V(0,_net1)-5)+(-5)*u((-5)-1E6*V(0,_net1))
RFN _net1 tn  10000 tc1=0.0 tc2=0.0
B_OPD S 0 V = 1E6*V(_net3,_net2)*u(5-1E6*V(_net3,_net2))*u(1E6*V(_net3,_net2)-(-5))+5*u(1E6*V(_net3,_net2)-5)+(-5)*u((-5)-1E6*V(_net3,_net2))
RD3 tn _net3  100000 tc1=0.0 tc2=0.0
RD4 _net3 0  100000 tc1=0.0 tc2=0.0
RD1 tp _net2  100000 tc1=0.0 tc2=0.0
RD2 _net2 S  100000 tc1=0.0 tc2=0.0

.control

op
print v(S) v(bias) v(in0) v(in1) v(in2) v(in3) v(tn) v(tp)   > spice4qucs.dc1.ngspice.dc.print
destroy all
reset

exit
.endc
.END
