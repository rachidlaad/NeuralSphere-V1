* validation divider
V1 in 0 DC 5
R1 in mid 10k
R2 mid 0 4.7k
.control
op
print v(mid) i(V1)
quit
.endc
.end
