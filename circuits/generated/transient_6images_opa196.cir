* NeuralSphere-V1 differential resistive crossbar: 64 inputs + bias -> 10 outputs
* amplifier model: OPA196
.include "C:/Users/intel/Documents/NeuralSphere-V1/circuits/models/neuralsphere_models.lib"
.include "C:/Users/intel/Documents/NeuralSphere-V1/tools/vendor_models/opa196_extracted/OPAx196.LIB"
.include "C:/Users/intel/Documents/NeuralSphere-V1/circuits/models/opa196_wrapper.lib"
* ---- supplies and reference rail
VCC vcc 0 DC 5
VEE vee 0 DC -5
VB bias 0 DC 1
* ---- input voltage sources (one per pixel), values set per image by alter
VIN0 in0 0 PWL(0 0 2e-05 0 2.01e-05 0 4e-05 0 4.01e-05 0 6e-05 0 6.01e-05 0 8e-05 0 8.01e-05 0 0.0001 0 0.0001001 0)
VIN1 in1 0 PWL(0 0 2e-05 0 2.01e-05 0.1875 4e-05 0.1875 4.01e-05 0 6e-05 0 6.01e-05 0 8e-05 0 8.01e-05 0 0.0001 0 0.0001001 0.125)
VIN2 in2 0 PWL(0 0.5 2e-05 0.5 2.01e-05 1 4e-05 1 4.01e-05 0.125 6e-05 0.125 6.01e-05 0.1875 8e-05 0.1875 8.01e-05 0.375 0.0001 0.375 0.0001001 0.6875)
VIN3 in3 0 PWL(0 0.75 2e-05 0.75 2.01e-05 0.9375 4e-05 0.9375 4.01e-05 0.8125 6e-05 0.8125 6.01e-05 1 8e-05 1 8.01e-05 1 0.0001 1 0.0001001 1)
VIN4 in4 0 PWL(0 0.875 2e-05 0.875 2.01e-05 0.0625 4e-05 0.0625 4.01e-05 0.8125 6e-05 0.8125 6.01e-05 0.75 8e-05 0.75 8.01e-05 0.8125 0.0001 0.8125 0.0001001 0.9375)
VIN5 in5 0 PWL(0 0.75 2e-05 0.75 2.01e-05 0 4e-05 0 4.01e-05 0.0625 6e-05 0.0625 6.01e-05 0.0625 8e-05 0.0625 8.01e-05 0.75 0.0001 0.75 0.0001001 0.125)
VIN6 in6 0 PWL(0 0.1875 2e-05 0.1875 2.01e-05 0 4e-05 0 4.01e-05 0 6e-05 0 6.01e-05 0 8e-05 0 8.01e-05 0.875 0.0001 0.875 0.0001001 0)
VIN7 in7 0 PWL(0 0 2e-05 0 2.01e-05 0 4e-05 0 4.01e-05 0 6e-05 0 6.01e-05 0 8e-05 0 8.01e-05 0.0625 0.0001 0.0625 0.0001001 0)
VIN8 in8 0 PWL(0 0 2e-05 0 2.01e-05 0 4e-05 0 4.01e-05 0 6e-05 0 6.01e-05 0 8e-05 0 8.01e-05 0 0.0001 0 0.0001001 0)
VIN9 in9 0 PWL(0 0 2e-05 0 2.01e-05 0.625 4e-05 0.625 4.01e-05 0 6e-05 0 6.01e-05 0 8e-05 0 8.01e-05 0 0.0001 0 0.0001001 0.75)
VIN10 in10 0 PWL(0 0.75 2e-05 0.75 2.01e-05 1 4e-05 1 4.01e-05 0.5 6e-05 0.5 6.01e-05 0.625 8e-05 0.625 8.01e-05 0.875 0.0001 0.875 0.0001001 1)
VIN11 in11 0 PWL(0 0.3125 2e-05 0.3125 2.01e-05 0.9375 4e-05 0.9375 4.01e-05 1 6e-05 1 6.01e-05 1 8e-05 1 8.01e-05 0.25 0.0001 0.25 0.0001001 0.9375)
VIN12 in12 0 PWL(0 0 2e-05 0 2.01e-05 0.375 4e-05 0.375 4.01e-05 0.875 6e-05 0.875 6.01e-05 1 8e-05 1 8.01e-05 0.25 0.0001 0.25 0.0001001 1)
VIN13 in13 0 PWL(0 0.1875 2e-05 0.1875 2.01e-05 0 4e-05 0 4.01e-05 0.25 6e-05 0.25 6.01e-05 0 8e-05 0 8.01e-05 0.9375 0.0001 0.9375 0.0001001 0.25)
VIN14 in14 0 PWL(0 0 2e-05 0 2.01e-05 0 4e-05 0 4.01e-05 0 6e-05 0 6.01e-05 0 8e-05 0 8.01e-05 0.25 0.0001 0.25 0.0001001 0)
VIN15 in15 0 PWL(0 0 2e-05 0 2.01e-05 0 4e-05 0 4.01e-05 0 6e-05 0 6.01e-05 0 8e-05 0 8.01e-05 0 0.0001 0 0.0001001 0)
VIN16 in16 0 PWL(0 0 2e-05 0 2.01e-05 0 4e-05 0 4.01e-05 0 6e-05 0 6.01e-05 0 8e-05 0 8.01e-05 0 0.0001 0 0.0001001 0)
VIN17 in17 0 PWL(0 0 2e-05 0 2.01e-05 0.8125 4e-05 0.8125 4.01e-05 0 6e-05 0 6.01e-05 0 8e-05 0 8.01e-05 0.0625 0.0001 0.0625 0.0001001 0.125)
VIN18 in18 0 PWL(0 1 2e-05 1 2.01e-05 0.625 4e-05 0.625 4.01e-05 0.3125 6e-05 0.3125 6.01e-05 0.75 8e-05 0.75 8.01e-05 0.4375 0.0001 0.4375 0.0001001 0.1875)
VIN19 in19 0 PWL(0 0.125 2e-05 0.125 2.01e-05 0.8125 4e-05 0.8125 4.01e-05 1 6e-05 1 6.01e-05 1 8e-05 1 8.01e-05 0 0.0001 0 0.0001001 0.125)
VIN20 in20 0 PWL(0 0.25 2e-05 0.25 2.01e-05 0.5 4e-05 0.5 4.01e-05 0.625 6e-05 0.625 6.01e-05 0.75 8e-05 0.75 8.01e-05 0.625 0.0001 0.625 0.0001001 1)
VIN21 in21 0 PWL(0 0.0625 2e-05 0.0625 2.01e-05 0 4e-05 0 4.01e-05 0.5 6e-05 0.5 6.01e-05 0 8e-05 0 8.01e-05 0.4375 0.0001 0.4375 0.0001001 0.25)
VIN22 in22 0 PWL(0 0 2e-05 0 2.01e-05 0 4e-05 0 4.01e-05 0.25 6e-05 0.25 6.01e-05 0 8e-05 0 8.01e-05 0 0.0001 0 0.0001001 0)
VIN23 in23 0 PWL(0 0 2e-05 0 2.01e-05 0 4e-05 0 4.01e-05 0 6e-05 0 6.01e-05 0 8e-05 0 8.01e-05 0 0.0001 0 0.0001001 0)
VIN24 in24 0 PWL(0 0 2e-05 0 2.01e-05 0 4e-05 0 4.01e-05 0 6e-05 0 6.01e-05 0 8e-05 0 8.01e-05 0 0.0001 0 0.0001001 0)
VIN25 in25 0 PWL(0 0.25 2e-05 0.25 2.01e-05 0.0625 4e-05 0.0625 4.01e-05 0 6e-05 0 6.01e-05 0 8e-05 0 8.01e-05 0 0.0001 0 0.0001001 0)
VIN26 in26 0 PWL(0 1 2e-05 1 2.01e-05 0.1875 4e-05 0.1875 4.01e-05 0.0625 6e-05 0.0625 6.01e-05 0.8125 8e-05 0.8125 8.01e-05 0 0.0001 0 0.0001001 0)
VIN27 in27 0 PWL(0 0.875 2e-05 0.875 2.01e-05 0.6875 4e-05 0.6875 4.01e-05 1 6e-05 1 6.01e-05 1 8e-05 1 8.01e-05 0.125 0.0001 0.125 0.0001001 0.625)
VIN28 in28 0 PWL(0 0.75 2e-05 0.75 2.01e-05 0.625 4e-05 0.625 4.01e-05 1 6e-05 1 6.01e-05 0.625 8e-05 0.625 8.01e-05 0.8125 0.0001 0.8125 0.0001001 0.875)
VIN29 in29 0 PWL(0 0.9375 2e-05 0.9375 2.01e-05 0 4e-05 0 4.01e-05 0.625 6e-05 0.625 6.01e-05 0 8e-05 0 8.01e-05 0.0625 0.0001 0.0625 0.0001001 0)
VIN30 in30 0 PWL(0 0.25 2e-05 0.25 2.01e-05 0 4e-05 0 4.01e-05 0.125 6e-05 0.125 6.01e-05 0 8e-05 0 8.01e-05 0 0.0001 0 0.0001001 0)
VIN31 in31 0 PWL(0 0 2e-05 0 2.01e-05 0 4e-05 0 4.01e-05 0 6e-05 0 6.01e-05 0 8e-05 0 8.01e-05 0 0.0001 0 0.0001001 0)
VIN32 in32 0 PWL(0 0 2e-05 0 2.01e-05 0 4e-05 0 4.01e-05 0 6e-05 0 6.01e-05 0 8e-05 0 8.01e-05 0 0.0001 0 0.0001001 0)
VIN33 in33 0 PWL(0 0 2e-05 0 2.01e-05 0 4e-05 0 4.01e-05 0.125 6e-05 0.125 6.01e-05 0 8e-05 0 8.01e-05 0.125 0.0001 0.125 0.0001001 0)
VIN34 in34 0 PWL(0 0.25 2e-05 0.25 2.01e-05 0 4e-05 0 4.01e-05 0.9375 6e-05 0.9375 6.01e-05 1 8e-05 1 8.01e-05 0.5625 0.0001 0.5625 0.0001001 0.25)
VIN35 in35 0 PWL(0 0 2e-05 0 2.01e-05 0.9375 4e-05 0.9375 4.01e-05 0.8125 6e-05 0.8125 6.01e-05 1 8e-05 1 8.01e-05 0.875 0.0001 0.875 0.0001001 1)
VIN36 in36 0 PWL(0 0 2e-05 0 2.01e-05 0.5 4e-05 0.5 4.01e-05 0.75 6e-05 0.75 6.01e-05 0.0625 8e-05 0.0625 8.01e-05 1 0.0001 1 0.0001001 0.3125)
VIN37 in37 0 PWL(0 0.5 2e-05 0.5 2.01e-05 0 4e-05 0 4.01e-05 0 6e-05 0 6.01e-05 0 8e-05 0 8.01e-05 0.75 0.0001 0.75 0.0001001 0)
VIN38 in38 0 PWL(0 0.5 2e-05 0.5 2.01e-05 0 4e-05 0 4.01e-05 0 6e-05 0 6.01e-05 0 8e-05 0 8.01e-05 0 0.0001 0 0.0001001 0)
VIN39 in39 0 PWL(0 0 2e-05 0 2.01e-05 0 4e-05 0 4.01e-05 0 6e-05 0 6.01e-05 0 8e-05 0 8.01e-05 0 0.0001 0 0.0001001 0)
VIN40 in40 0 PWL(0 0 2e-05 0 2.01e-05 0 4e-05 0 4.01e-05 0 6e-05 0 6.01e-05 0 8e-05 0 8.01e-05 0 0.0001 0 0.0001001 0)
VIN41 in41 0 PWL(0 0.0625 2e-05 0.0625 2.01e-05 0 4e-05 0 4.01e-05 0.3125 6e-05 0.3125 6.01e-05 0 8e-05 0 8.01e-05 0.25 0.0001 0.25 0.0001001 0)
VIN42 in42 0 PWL(0 0 2e-05 0 2.01e-05 0.25 4e-05 0.25 4.01e-05 0.75 6e-05 0.75 6.01e-05 1 8e-05 1 8.01e-05 0.375 0.0001 0.375 0.0001001 0.75)
VIN43 in43 0 PWL(0 0 2e-05 0 2.01e-05 1 4e-05 1 4.01e-05 0.1875 6e-05 0.1875 6.01e-05 1 8e-05 1 8.01e-05 0.9375 0.0001 0.9375 0.0001001 0.75)
VIN44 in44 0 PWL(0 0 2e-05 0 2.01e-05 0.625 4e-05 0.625 4.01e-05 0.9375 6e-05 0.9375 6.01e-05 0 8e-05 0 8.01e-05 0.125 0.0001 0.125 0.0001001 0.1875)
VIN45 in45 0 PWL(0 0.6875 2e-05 0.6875 2.01e-05 0.3125 4e-05 0.3125 4.01e-05 0.0625 6e-05 0.0625 6.01e-05 0 8e-05 0 8.01e-05 0.25 0.0001 0.25 0.0001001 0.6875)
VIN46 in46 0 PWL(0 0.3125 2e-05 0.3125 2.01e-05 0.4375 4e-05 0.4375 4.01e-05 0 6e-05 0 6.01e-05 0 8e-05 0 8.01e-05 0.0625 0.0001 0.0625 0.0001001 0.5625)
VIN47 in47 0 PWL(0 0 2e-05 0 2.01e-05 0 4e-05 0 4.01e-05 0 6e-05 0 6.01e-05 0 8e-05 0 8.01e-05 0 0.0001 0 0.0001001 0)
VIN48 in48 0 PWL(0 0 2e-05 0 2.01e-05 0 4e-05 0 4.01e-05 0 6e-05 0 6.01e-05 0 8e-05 0 8.01e-05 0 0.0001 0 0.0001001 0)
VIN49 in49 0 PWL(0 0.375 2e-05 0.375 2.01e-05 0.0625 4e-05 0.0625 4.01e-05 0 6e-05 0 6.01e-05 0 8e-05 0 8.01e-05 0 0.0001 0 0.0001001 0)
VIN50 in50 0 PWL(0 0.875 2e-05 0.875 2.01e-05 0.8125 4e-05 0.8125 4.01e-05 0.875 6e-05 0.875 6.01e-05 0.625 8e-05 0.625 8.01e-05 0.375 0.0001 0.375 0.0001001 1)
VIN51 in51 0 PWL(0 0.0625 2e-05 0.0625 2.01e-05 1 4e-05 1 4.01e-05 0.1875 6e-05 0.1875 6.01e-05 1 8e-05 1 8.01e-05 0.4375 0.0001 0.4375 0.0001001 1)
VIN52 in52 0 PWL(0 0.125 2e-05 0.125 2.01e-05 1 4e-05 1 4.01e-05 0.8125 6e-05 0.8125 6.01e-05 0.0625 8e-05 0.0625 8.01e-05 0 0.0001 0 0.0001001 1)
VIN53 in53 0 PWL(0 0.9375 2e-05 0.9375 2.01e-05 1 4e-05 1 4.01e-05 0.25 6e-05 0.25 6.01e-05 0 8e-05 0 8.01e-05 0 0.0001 0 0.0001001 1)
VIN54 in54 0 PWL(0 0.0625 2e-05 0.0625 2.01e-05 1 4e-05 1 4.01e-05 0 6e-05 0 6.01e-05 0 8e-05 0 8.01e-05 0 0.0001 0 0.0001001 0.375)
VIN55 in55 0 PWL(0 0 2e-05 0 2.01e-05 0 4e-05 0 4.01e-05 0 6e-05 0 6.01e-05 0 8e-05 0 8.01e-05 0 0.0001 0 0.0001001 0)
VIN56 in56 0 PWL(0 0 2e-05 0 2.01e-05 0 4e-05 0 4.01e-05 0 6e-05 0 6.01e-05 0 8e-05 0 8.01e-05 0 0.0001 0 0.0001001 0)
VIN57 in57 0 PWL(0 0 2e-05 0 2.01e-05 0.125 4e-05 0.125 4.01e-05 0 6e-05 0 6.01e-05 0 8e-05 0 8.01e-05 0 0.0001 0 0.0001001 0)
VIN58 in58 0 PWL(0 0.5 2e-05 0.5 2.01e-05 0.875 4e-05 0.875 4.01e-05 0.1875 6e-05 0.1875 6.01e-05 0.125 8e-05 0.125 8.01e-05 0.625 0.0001 0.625 0.0001001 0.875)
VIN59 in59 0 PWL(0 0.875 2e-05 0.875 2.01e-05 0.9375 4e-05 0.9375 4.01e-05 0.9375 6e-05 0.9375 6.01e-05 0.8125 8e-05 0.8125 8.01e-05 0.25 0.0001 0.25 0.0001001 0.9375)
VIN60 in60 0 PWL(0 1 2e-05 1 2.01e-05 0.6875 4e-05 0.6875 4.01e-05 0.8125 6e-05 0.8125 6.01e-05 0.5625 8e-05 0.5625 8.01e-05 0 0.0001 0 0.0001001 0.75)
VIN61 in61 0 PWL(0 0.25 2e-05 0.25 2.01e-05 0.5 4e-05 0.5 4.01e-05 0.0625 6e-05 0.0625 6.01e-05 0 8e-05 0 8.01e-05 0 0.0001 0 0.0001001 0.3125)
VIN62 in62 0 PWL(0 0 2e-05 0 2.01e-05 0.1875 4e-05 0.1875 4.01e-05 0 6e-05 0 6.01e-05 0 8e-05 0 8.01e-05 0 0.0001 0 0.0001001 0)
VIN63 in63 0 PWL(0 0 2e-05 0 2.01e-05 0 4e-05 0 4.01e-05 0 6e-05 0 6.01e-05 0 8e-05 0 8.01e-05 0 0.0001 0 0.0001001 0)
* ---- synapses: one resistor per conductance, R = 1/G
RP0_0 in0 cp0 1000000
RN0_0 in0 cn0 1000000
RP0_1 in1 cp0 1000000
RN0_1 in1 cn0 334245.873
RP0_2 in2 cp0 1000000
RN0_2 in2 cn0 284502.384
RP0_3 in3 cp0 58567.1828
RN0_3 in3 cn0 1000000
RP0_4 in4 cp0 903772.749
RN0_4 in4 cn0 1000000
RP0_5 in5 cp0 1000000
RN0_5 in5 cn0 37775.3623
RP0_6 in6 cp0 1000000
RN0_6 in6 cn0 54492.5639
RP0_7 in7 cp0 1000000
RN0_7 in7 cn0 326625.169
RP0_8 in8 cp0 1000000
RN0_8 in8 cn0 980935.982
RP0_9 in9 cp0 1000000
RN0_9 in9 cn0 99072.1848
RP0_10 in10 cp0 109522.406
RN0_10 in10 cn0 1000000
RP0_11 in11 cp0 54615.7731
RN0_11 in11 cn0 1000000
RP0_12 in12 cp0 61509.4589
RN0_12 in12 cn0 1000000
RP0_13 in13 cp0 34529.5011
RN0_13 in13 cn0 1000000
RP0_14 in14 cp0 1000000
RN0_14 in14 cn0 89181.9146
RP0_15 in15 cp0 1000000
RN0_15 in15 cn0 323210.457
RP0_16 in16 cp0 1000000
RN0_16 in16 cn0 999142.134
RP0_17 in17 cp0 127752.094
RN0_17 in17 cn0 1000000
RP0_18 in18 cp0 37206.6883
RN0_18 in18 cn0 1000000
RP0_19 in19 cp0 1000000
RN0_19 in19 cn0 97934.5368
RP0_20 in20 cp0 1000000
RN0_20 in20 cn0 22794.3379
RP0_21 in21 cp0 29816.3402
RN0_21 in21 cn0 1000000
RP0_22 in22 cp0 79858.9106
RN0_22 in22 cn0 1000000
RP0_23 in23 cp0 1000000
RN0_23 in23 cn0 629392.797
RP0_24 in24 cp0 1000000
RN0_24 in24 cn0 999325.617
RP0_25 in25 cp0 42574.8042
RN0_25 in25 cn0 1000000
RP0_26 in26 cp0 44109.9115
RN0_26 in26 cn0 1000000
RP0_27 in27 cp0 1000000
RN0_27 in27 cn0 24338.9484
RP0_28 in28 cp0 1000000
RN0_28 in28 cn0 12163.6226
RP0_29 in29 cp0 1000000
RN0_29 in29 cn0 506915.172
RP0_30 in30 cp0 33336.8944
RN0_30 in30 cn0 1000000
RP0_31 in31 cp0 1000000
RN0_31 in31 cn0 904565.93
RP0_32 in32 cp0 1000000
RN0_32 in32 cn0 1000000
RP0_33 in33 cp0 30349.4876
RN0_33 in33 cn0 1000000
RP0_34 in34 cp0 39235.922
RN0_34 in34 cn0 1000000
RP0_35 in35 cp0 1000000
RN0_35 in35 cn0 20253.5726
RP0_36 in36 cp0 1000000
RN0_36 in36 cn0 13746.1777
RP0_37 in37 cp0 1000000
RN0_37 in37 cn0 294240.773
RP0_38 in38 cp0 40275.1523
RN0_38 in38 cn0 1000000
RP0_39 in39 cp0 1000000
RN0_39 in39 cn0 1000000
RP0_40 in40 cp0 1000000
RN0_40 in40 cn0 812644.971
RP0_41 in41 cp0 133131.47
RN0_41 in41 cn0 1000000
RP0_42 in42 cp0 20656.4296
RN0_42 in42 cn0 1000000
RP0_43 in43 cp0 1000000
RN0_43 in43 cn0 39700.7168
RP0_44 in44 cp0 1000000
RN0_44 in44 cn0 26405.2889
RP0_45 in45 cp0 57763.5532
RN0_45 in45 cn0 1000000
RP0_46 in46 cp0 94915.3109
RN0_46 in46 cn0 1000000
RP0_47 in47 cp0 1000000
RN0_47 in47 cn0 949833.26
RP0_48 in48 cp0 1000000
RN0_48 in48 cn0 558487.523
RP0_49 in49 cp0 1000000
RN0_49 in49 cn0 93920.1855
RP0_50 in50 cp0 37831.8068
RN0_50 in50 cn0 1000000
RP0_51 in51 cp0 386363.707
RN0_51 in51 cn0 1000000
RP0_52 in52 cp0 58956.6001
RN0_52 in52 cn0 1000000
RP0_53 in53 cp0 54167.0251
RN0_53 in53 cn0 1000000
RP0_54 in54 cp0 1000000
RN0_54 in54 cn0 70288.7989
RP0_55 in55 cp0 1000000
RN0_55 in55 cn0 547947.654
RP0_56 in56 cp0 1000000
RN0_56 in56 cn0 994221.312
RP0_57 in57 cp0 1000000
RN0_57 in57 cn0 393486.397
RP0_58 in58 cp0 1000000
RN0_58 in58 cn0 125386.923
RP0_59 in59 cp0 65136.337
RN0_59 in59 cn0 1000000
RP0_60 in60 cp0 1000000
RN0_60 in60 cn0 201560.921
RP0_61 in61 cp0 1000000
RN0_61 in61 cn0 65936.7845
RP0_62 in62 cp0 1000000
RN0_62 in62 cn0 72259.0205
RP0_63 in63 cp0 1000000
RN0_63 in63 cn0 299428.236
RP0_64 bias cp0 342155.977
RN0_64 bias cn0 1000000
RP1_0 in0 cp1 1000000
RN1_0 in0 cn1 1000000
RP1_1 in1 cp1 1000000
RN1_1 in1 cn1 194177.359
RP1_2 in2 cp1 1000000
RN1_2 in2 cn1 83915.5903
RP1_3 in3 cp1 1000000
RN1_3 in3 cn1 619582.702
RP1_4 in4 cp1 1000000
RN1_4 in4 cn1 13884.41
RP1_5 in5 cp1 32904.3661
RN1_5 in5 cn1 1000000
RP1_6 in6 cp1 532835.836
RN1_6 in6 cn1 1000000
RP1_7 in7 cp1 1000000
RN1_7 in7 cn1 305905.091
RP1_8 in8 cp1 1000000
RN1_8 in8 cn1 757850.93
RP1_9 in9 cp1 1000000
RN1_9 in9 cn1 26712.8393
RP1_10 in10 cp1 1000000
RN1_10 in10 cn1 13819.0932
RP1_11 in11 cp1 1000000
RN1_11 in11 cn1 79208.8884
RP1_12 in12 cp1 48182.8676
RN1_12 in12 cn1 1000000
RP1_13 in13 cp1 72988.3707
RN1_13 in13 cn1 1000000
RP1_14 in14 cp1 1000000
RN1_14 in14 cn1 36065.4926
RP1_15 in15 cp1 1000000
RN1_15 in15 cn1 334273.466
RP1_16 in16 cp1 1000000
RN1_16 in16 cn1 987297.493
RP1_17 in17 cp1 858077.902
RN1_17 in17 cn1 1000000
RP1_18 in18 cp1 1000000
RN1_18 in18 cn1 63830.8442
RP1_19 in19 cp1 10460.0244
RN1_19 in19 cn1 1000000
RP1_20 in20 cp1 10922.4733
RN1_20 in20 cn1 1000000
RP1_21 in21 cp1 1000000
RN1_21 in21 cn1 96744.9471
RP1_22 in22 cp1 1000000
RN1_22 in22 cn1 80312.6498
RP1_23 in23 cp1 1000000
RN1_23 in23 cn1 568106.446
RP1_24 in24 cp1 1000000
RN1_24 in24 cn1 851400.499
RP1_25 in25 cp1 1000000
RN1_25 in25 cn1 399602.619
RP1_26 in26 cp1 56328.3819
RN1_26 in26 cn1 1000000
RP1_27 in27 cp1 22127.1294
RN1_27 in27 cn1 1000000
RP1_28 in28 cp1 48082.4228
RN1_28 in28 cn1 1000000
RP1_29 in29 cp1 118508.271
RN1_29 in29 cn1 1000000
RP1_30 in30 cp1 1000000
RN1_30 in30 cn1 72103.2175
RP1_31 in31 cp1 1000000
RN1_31 in31 cn1 974536.079
RP1_32 in32 cp1 1000000
RN1_32 in32 cn1 1000000
RP1_33 in33 cp1 1000000
RN1_33 in33 cn1 235678.842
RP1_34 in34 cp1 466930.042
RN1_34 in34 cn1 1000000
RP1_35 in35 cp1 1000000
RN1_35 in35 cn1 139193.347
RP1_36 in36 cp1 67155.0225
RN1_36 in36 cn1 1000000
RP1_37 in37 cp1 1000000
RN1_37 in37 cn1 191448.83
RP1_38 in38 cp1 1000000
RN1_38 in38 cn1 38217.5425
RP1_39 in39 cp1 1000000
RN1_39 in39 cn1 1000000
RP1_40 in40 cp1 1000000
RN1_40 in40 cn1 927895.889
RP1_41 in41 cp1 1000000
RN1_41 in41 cn1 37982.2299
RP1_42 in42 cp1 1000000
RN1_42 in42 cn1 57711.4015
RP1_43 in43 cp1 41317.3352
RN1_43 in43 cn1 1000000
RP1_44 in44 cp1 25542.9054
RN1_44 in44 cn1 1000000
RP1_45 in45 cp1 1000000
RN1_45 in45 cn1 26166.2815
RP1_46 in46 cp1 1000000
RN1_46 in46 cn1 20537.4583
RP1_47 in47 cp1 1000000
RN1_47 in47 cn1 651294.205
RP1_48 in48 cp1 1000000
RN1_48 in48 cn1 708474.236
RP1_49 in49 cp1 1000000
RN1_49 in49 cn1 58763.1883
RP1_50 in50 cp1 1000000
RN1_50 in50 cn1 57565.9184
RP1_51 in51 cp1 45559.434
RN1_51 in51 cn1 1000000
RP1_52 in52 cp1 22104.6426
RN1_52 in52 cn1 1000000
RP1_53 in53 cp1 1000000
RN1_53 in53 cn1 120742.948
RP1_54 in54 cp1 1000000
RN1_54 in54 cn1 51063.9398
RP1_55 in55 cp1 58451.8608
RN1_55 in55 cn1 1000000
RP1_56 in56 cp1 1000000
RN1_56 in56 cn1 894253.913
RP1_57 in57 cp1 1000000
RN1_57 in57 cn1 225900.364
RP1_58 in58 cp1 1000000
RN1_58 in58 cn1 36012.6469
RP1_59 in59 cp1 1000000
RN1_59 in59 cn1 79066.2682
RP1_60 in60 cp1 98287.5395
RN1_60 in60 cn1 1000000
RP1_61 in61 cp1 22294.9576
RN1_61 in61 cn1 1000000
RP1_62 in62 cp1 30640.8262
RN1_62 in62 cn1 1000000
RP1_63 in63 cp1 28526.0146
RN1_63 in63 cn1 1000000
RP1_64 bias cp1 1000000
RN1_64 bias cn1 15459.564
RP2_0 in0 cp2 1000000
RN2_0 in0 cn2 1000000
RP2_1 in1 cp2 184437.018
RN2_1 in1 cn2 1000000
RP2_2 in2 cp2 49637.5824
RN2_2 in2 cn2 1000000
RP2_3 in3 cp2 98362.0143
RN2_3 in3 cn2 1000000
RP2_4 in4 cp2 378746.546
RN2_4 in4 cn2 1000000
RP2_5 in5 cp2 1000000
RN2_5 in5 cn2 84368.6116
RP2_6 in6 cp2 1000000
RN2_6 in6 cn2 118942.838
RP2_7 in7 cp2 1000000
RN2_7 in7 cn2 628258.727
RP2_8 in8 cp2 1000000
RN2_8 in8 cn2 944312.26
RP2_9 in9 cp2 31984.4037
RN2_9 in9 cn2 1000000
RP2_10 in10 cp2 63289.6828
RN2_10 in10 cn2 1000000
RP2_11 in11 cp2 1000000
RN2_11 in11 cn2 171460.993
RP2_12 in12 cp2 34658.0451
RN2_12 in12 cn2 1000000
RP2_13 in13 cp2 1000000
RN2_13 in13 cn2 209904.786
RP2_14 in14 cp2 1000000
RN2_14 in14 cn2 226868.619
RP2_15 in15 cp2 1000000
RN2_15 in15 cn2 572379.999
RP2_16 in16 cp2 903350.526
RN2_16 in16 cn2 1000000
RP2_17 in17 cp2 743188.012
RN2_17 in17 cn2 1000000
RP2_18 in18 cp2 1000000
RN2_18 in18 cn2 41675.3464
RP2_19 in19 cp2 1000000
RN2_19 in19 cn2 31164.5653
RP2_20 in20 cp2 52844.9307
RN2_20 in20 cn2 1000000
RP2_21 in21 cp2 683382.86
RN2_21 in21 cn2 1000000
RP2_22 in22 cp2 90660.3971
RN2_22 in22 cn2 1000000
RP2_23 in23 cp2 1000000
RN2_23 in23 cn2 964510.752
RP2_24 in24 cp2 1000000
RN2_24 in24 cn2 998872.969
RP2_25 in25 cp2 1000000
RN2_25 in25 cn2 51074.1939
RP2_26 in26 cp2 1000000
RN2_26 in26 cn2 12120.5583
RP2_27 in27 cp2 1000000
RN2_27 in27 cn2 12782.4321
RP2_28 in28 cp2 1000000
RN2_28 in28 cn2 50698.71
RP2_29 in29 cp2 428611.485
RN2_29 in29 cn2 1000000
RP2_30 in30 cp2 1000000
RN2_30 in30 cn2 195063.421
RP2_31 in31 cp2 1000000
RN2_31 in31 cn2 997918.27
RP2_32 in32 cp2 1000000
RN2_32 in32 cn2 1000000
RP2_33 in33 cp2 1000000
RN2_33 in33 cn2 59706.6449
RP2_34 in34 cp2 1000000
RN2_34 in34 cn2 17455.9277
RP2_35 in35 cp2 1000000
RN2_35 in35 cn2 46966.5974
RP2_36 in36 cp2 1000000
RN2_36 in36 cn2 166807.531
RP2_37 in37 cp2 1000000
RN2_37 in37 cn2 22713.8444
RP2_38 in38 cp2 1000000
RN2_38 in38 cn2 33704.644
RP2_39 in39 cp2 1000000
RN2_39 in39 cn2 1000000
RP2_40 in40 cp2 1000000
RN2_40 in40 cn2 994963.855
RP2_41 in41 cp2 99650.3986
RN2_41 in41 cn2 1000000
RP2_42 in42 cp2 80112.2958
RN2_42 in42 cn2 1000000
RP2_43 in43 cp2 15219.4271
RN2_43 in43 cn2 1000000
RP2_44 in44 cp2 1000000
RN2_44 in44 cn2 33737.7514
RP2_45 in45 cp2 1000000
RN2_45 in45 cn2 15129.2358
RP2_46 in46 cp2 1000000
RN2_46 in46 cn2 31621.2601
RP2_47 in47 cp2 640582.924
RN2_47 in47 cn2 1000000
RP2_48 in48 cp2 534629.834
RN2_48 in48 cn2 1000000
RP2_49 in49 cp2 52899.5663
RN2_49 in49 cn2 1000000
RP2_50 in50 cp2 49908.894
RN2_50 in50 cn2 1000000
RP2_51 in51 cp2 14567.4601
RN2_51 in51 cn2 1000000
RP2_52 in52 cp2 19911.5599
RN2_52 in52 cn2 1000000
RP2_53 in53 cp2 21768.2173
RN2_53 in53 cn2 1000000
RP2_54 in54 cp2 38688.1799
RN2_54 in54 cn2 1000000
RP2_55 in55 cp2 159080.935
RN2_55 in55 cn2 1000000
RP2_56 in56 cp2 772337.274
RN2_56 in56 cn2 1000000
RP2_57 in57 cp2 121687.926
RN2_57 in57 cn2 1000000
RP2_58 in58 cp2 39906.9169
RN2_58 in58 cn2 1000000
RP2_59 in59 cp2 95206.3236
RN2_59 in59 cn2 1000000
RP2_60 in60 cp2 79516.8405
RN2_60 in60 cn2 1000000
RP2_61 in61 cp2 19057.2617
RN2_61 in61 cn2 1000000
RP2_62 in62 cp2 17446.4109
RN2_62 in62 cn2 1000000
RP2_63 in63 cp2 58073.7633
RN2_63 in63 cn2 1000000
RP2_64 bias cp2 84629.4429
RN2_64 bias cn2 1000000
RP3_0 in0 cp3 1000000
RN3_0 in0 cn3 1000000
RP3_1 in1 cp3 142505.894
RN3_1 in1 cn3 1000000
RP3_2 in2 cp3 1000000
RN3_2 in2 cn3 182853.777
RP3_3 in3 cp3 61866.7145
RN3_3 in3 cn3 1000000
RP3_4 in4 cp3 16742.3813
RN3_4 in4 cn3 1000000
RP3_5 in5 cp3 33321.923
RN3_5 in5 cn3 1000000
RP3_6 in6 cp3 364143.18
RN3_6 in6 cn3 1000000
RP3_7 in7 cp3 1000000
RN3_7 in7 cn3 517162.859
RP3_8 in8 cp3 1000000
RN3_8 in8 cn3 781620.478
RP3_9 in9 cp3 55813.5273
RN3_9 in9 cn3 1000000
RP3_10 in10 cp3 49252.1376
RN3_10 in10 cn3 1000000
RP3_11 in11 cp3 1000000
RN3_11 in11 cn3 293359.933
RP3_12 in12 cp3 90836.757
RN3_12 in12 cn3 1000000
RP3_13 in13 cp3 36160.1824
RN3_13 in13 cn3 1000000
RP3_14 in14 cp3 44343.5551
RN3_14 in14 cn3 1000000
RP3_15 in15 cp3 1000000
RN3_15 in15 cn3 470396.426
RP3_16 in16 cp3 1000000
RN3_16 in16 cn3 956178.878
RP3_17 in17 cp3 1000000
RN3_17 in17 cn3 202546.782
RP3_18 in18 cp3 1000000
RN3_18 in18 cn3 13252.1181
RP3_19 in19 cp3 1000000
RN3_19 in19 cn3 16376.2693
RP3_20 in20 cp3 30753.0503
RN3_20 in20 cn3 1000000
RP3_21 in21 cp3 1000000
RN3_21 in21 cn3 52369.328
RP3_22 in22 cp3 1000000
RN3_22 in22 cn3 152343.909
RP3_23 in23 cp3 1000000
RN3_23 in23 cn3 709580.662
RP3_24 in24 cp3 1000000
RN3_24 in24 cn3 999533.451
RP3_25 in25 cp3 1000000
RN3_25 in25 cn3 47737.8928
RP3_26 in26 cp3 1000000
RN3_26 in26 cn3 13037.642
RP3_27 in27 cp3 1000000
RN3_27 in27 cn3 75630.4628
RP3_28 in28 cp3 28094.2868
RN3_28 in28 cn3 1000000
RP3_29 in29 cp3 1000000
RN3_29 in29 cn3 13901.8879
RP3_30 in30 cp3 1000000
RN3_30 in30 cn3 25740.0621
RP3_31 in31 cp3 1000000
RN3_31 in31 cn3 998404.173
RP3_32 in32 cp3 1000000
RN3_32 in32 cn3 1000000
RP3_33 in33 cp3 1000000
RN3_33 in33 cn3 77319.4045
RP3_34 in34 cp3 1000000
RN3_34 in34 cn3 28855.7661
RP3_35 in35 cp3 1000000
RN3_35 in35 cn3 148003.28
RP3_36 in36 cp3 28511.0036
RN3_36 in36 cn3 1000000
RP3_37 in37 cp3 231175.606
RN3_37 in37 cn3 1000000
RP3_38 in38 cp3 1000000
RN3_38 in38 cn3 111708.31
RP3_39 in39 cp3 1000000
RN3_39 in39 cn3 1000000
RP3_40 in40 cp3 1000000
RN3_40 in40 cn3 998021.509
RP3_41 in41 cp3 1000000
RN3_41 in41 cn3 183146.424
RP3_42 in42 cp3 1000000
RN3_42 in42 cn3 20355.8963
RP3_43 in43 cp3 1000000
RN3_43 in43 cn3 14293.7715
RP3_44 in44 cp3 130557.928
RN3_44 in44 cn3 1000000
RP3_45 in45 cp3 22079.44
RN3_45 in45 cn3 1000000
RP3_46 in46 cp3 23012.4845
RN3_46 in46 cn3 1000000
RP3_47 in47 cp3 1000000
RN3_47 in47 cn3 717303.684
RP3_48 in48 cp3 1000000
RN3_48 in48 cn3 984534.416
RP3_49 in49 cp3 1000000
RN3_49 in49 cn3 194388.394
RP3_50 in50 cp3 1000000
RN3_50 in50 cn3 127980.533
RP3_51 in51 cp3 1000000
RN3_51 in51 cn3 29111.2192
RP3_52 in52 cp3 94769.4651
RN3_52 in52 cn3 1000000
RP3_53 in53 cp3 36896.3245
RN3_53 in53 cn3 1000000
RP3_54 in54 cp3 25893.023
RN3_54 in54 cn3 1000000
RP3_55 in55 cp3 1000000
RN3_55 in55 cn3 121786.699
RP3_56 in56 cp3 1000000
RN3_56 in56 cn3 995805.523
RP3_57 in57 cp3 197256.676
RN3_57 in57 cn3 1000000
RP3_58 in58 cp3 40597.5432
RN3_58 in58 cn3 1000000
RP3_59 in59 cp3 57477.0272
RN3_59 in59 cn3 1000000
RP3_60 in60 cp3 55382.9839
RN3_60 in60 cn3 1000000
RP3_61 in61 cp3 106977.13
RN3_61 in61 cn3 1000000
RP3_62 in62 cp3 1000000
RN3_62 in62 cn3 101608.254
RP3_63 in63 cp3 1000000
RN3_63 in63 cn3 58709.323
RP3_64 bias cp3 55824.434
RN3_64 bias cn3 1000000
RP4_0 in0 cp4 1000000
RN4_0 in0 cn4 1000000
RP4_1 in1 cp4 1000000
RN4_1 in1 cn4 298894.704
RP4_2 in2 cp4 1000000
RN4_2 in2 cn4 46546.8616
RP4_3 in3 cp4 1000000
RN4_3 in3 cn4 17860.811
RP4_4 in4 cp4 1000000
RN4_4 in4 cn4 33382.0896
RP4_5 in5 cp4 1000000
RN4_5 in5 cn4 17129.3741
RP4_6 in6 cp4 1000000
RN4_6 in6 cn4 37306.3218
RP4_7 in7 cp4 198863.502
RN4_7 in7 cn4 1000000
RP4_8 in8 cp4 1000000
RN4_8 in8 cn4 933834.19
RP4_9 in9 cp4 1000000
RN4_9 in9 cn4 514599.595
RP4_10 in10 cp4 1000000
RN4_10 in10 cn4 28354.9929
RP4_11 in11 cp4 1000000
RN4_11 in11 cn4 39869.698
RP4_12 in12 cp4 1000000
RN4_12 in12 cn4 24800.1989
RP4_13 in13 cp4 1000000
RN4_13 in13 cn4 22947.4998
RP4_14 in14 cp4 1000000
RN4_14 in14 cn4 54330.8454
RP4_15 in15 cp4 838167.354
RN4_15 in15 cn4 1000000
RP4_16 in16 cp4 1000000
RN4_16 in16 cn4 999382.85
RP4_17 in17 cp4 1000000
RN4_17 in17 cn4 797066.677
RP4_18 in18 cp4 57956.324
RN4_18 in18 cn4 1000000
RP4_19 in19 cp4 39253.9452
RN4_19 in19 cn4 1000000
RP4_20 in20 cp4 179745.677
RN4_20 in20 cn4 1000000
RP4_21 in21 cp4 398401.615
RN4_21 in21 cn4 1000000
RP4_22 in22 cp4 156360.159
RN4_22 in22 cn4 1000000
RP4_23 in23 cp4 186728.513
RN4_23 in23 cn4 1000000
RP4_24 in24 cp4 748799.426
RN4_24 in24 cn4 1000000
RP4_25 in25 cp4 41999.5178
RN4_25 in25 cn4 1000000
RP4_26 in26 cp4 17311.5332
RN4_26 in26 cn4 1000000
RP4_27 in27 cp4 1000000
RN4_27 in27 cn4 237783.197
RP4_28 in28 cp4 556854.312
RN4_28 in28 cn4 1000000
RP4_29 in29 cp4 80060.0164
RN4_29 in29 cn4 1000000
RP4_30 in30 cp4 18046.875
RN4_30 in30 cn4 1000000
RP4_31 in31 cp4 494029.643
RN4_31 in31 cn4 1000000
RP4_32 in32 cp4 1000000
RN4_32 in32 cn4 1000000
RP4_33 in33 cp4 24306.1899
RN4_33 in33 cn4 1000000
RP4_34 in34 cp4 24469.3938
RN4_34 in34 cn4 1000000
RP4_35 in35 cp4 1000000
RN4_35 in35 cn4 237461.571
RP4_36 in36 cp4 29522.7321
RN4_36 in36 cn4 1000000
RP4_37 in37 cp4 23893.7154
RN4_37 in37 cn4 1000000
RP4_38 in38 cp4 25368.5359
RN4_38 in38 cn4 1000000
RP4_39 in39 cp4 1000000
RN4_39 in39 cn4 1000000
RP4_40 in40 cp4 613563.338
RN4_40 in40 cn4 1000000
RP4_41 in41 cp4 17213.1412
RN4_41 in41 cn4 1000000
RP4_42 in42 cp4 198385.549
RN4_42 in42 cn4 1000000
RP4_43 in43 cp4 17611.1043
RN4_43 in43 cn4 1000000
RP4_44 in44 cp4 17313.9619
RN4_44 in44 cn4 1000000
RP4_45 in45 cp4 68427.6927
RN4_45 in45 cn4 1000000
RP4_46 in46 cp4 539052.659
RN4_46 in46 cn4 1000000
RP4_47 in47 cp4 1000000
RN4_47 in47 cn4 782291.722
RP4_48 in48 cp4 435598.513
RN4_48 in48 cn4 1000000
RP4_49 in49 cp4 40961.4868
RN4_49 in49 cn4 1000000
RP4_50 in50 cp4 1000000
RN4_50 in50 cn4 37233.0359
RP4_51 in51 cp4 1000000
RN4_51 in51 cn4 932632.005
RP4_52 in52 cp4 71617.6719
RN4_52 in52 cn4 1000000
RP4_53 in53 cp4 1000000
RN4_53 in53 cn4 20517.1171
RP4_54 in54 cp4 1000000
RN4_54 in54 cn4 28262.3425
RP4_55 in55 cp4 1000000
RN4_55 in55 cn4 423336.63
RP4_56 in56 cp4 1000000
RN4_56 in56 cn4 987563.372
RP4_57 in57 cp4 1000000
RN4_57 in57 cn4 369273.751
RP4_58 in58 cp4 1000000
RN4_58 in58 cn4 66180.6856
RP4_59 in59 cp4 1000000
RN4_59 in59 cn4 23912.7077
RP4_60 in60 cp4 1000000
RN4_60 in60 cn4 50714.8664
RP4_61 in61 cp4 1000000
RN4_61 in61 cn4 22635.3388
RP4_62 in62 cp4 1000000
RN4_62 in62 cn4 69198.3635
RP4_63 in63 cp4 1000000
RN4_63 in63 cn4 416223.167
RP4_64 bias cp4 14428.4971
RN4_64 bias cn4 1000000
RP5_0 in0 cp5 1000000
RN5_0 in0 cn5 1000000
RP5_1 in1 cp5 92157.0101
RN5_1 in1 cn5 1000000
RP5_2 in2 cp5 16732.8181
RN5_2 in2 cn5 1000000
RP5_3 in3 cp5 1000000
RN5_3 in3 cn5 184293.379
RP5_4 in4 cp5 65685.6794
RN5_4 in4 cn5 1000000
RP5_5 in5 cp5 17304.3927
RN5_5 in5 cn5 1000000
RP5_6 in6 cp5 22740.4432
RN5_6 in6 cn5 1000000
RP5_7 in7 cp5 1000000
RN5_7 in7 cn5 112363.401
RP5_8 in8 cp5 952310.269
RN5_8 in8 cn5 1000000
RP5_9 in9 cp5 116207.46
RN5_9 in9 cn5 1000000
RP5_10 in10 cp5 29526.5456
RN5_10 in10 cn5 1000000
RP5_11 in11 cp5 51355.9126
RN5_11 in11 cn5 1000000
RP5_12 in12 cp5 1000000
RN5_12 in12 cn5 730336.077
RP5_13 in13 cp5 1000000
RN5_13 in13 cn5 28426.3512
RP5_14 in14 cp5 1000000
RN5_14 in14 cn5 205750.259
RP5_15 in15 cp5 1000000
RN5_15 in15 cn5 161060.604
RP5_16 in16 cp5 1000000
RN5_16 in16 cn5 994286.266
RP5_17 in17 cp5 72123.0811
RN5_17 in17 cn5 1000000
RP5_18 in18 cp5 27992.105
RN5_18 in18 cn5 1000000
RP5_19 in19 cp5 234554.864
RN5_19 in19 cn5 1000000
RP5_20 in20 cp5 1000000
RN5_20 in20 cn5 15167.1759
RP5_21 in21 cp5 1000000
RN5_21 in21 cn5 11355.6697
RP5_22 in22 cp5 1000000
RN5_22 in22 cn5 18307.1204
RP5_23 in23 cp5 1000000
RN5_23 in23 cn5 363977.559
RP5_24 in24 cp5 1000000
RN5_24 in24 cn5 893391.19
RP5_25 in25 cp5 31905.7936
RN5_25 in25 cn5 1000000
RP5_26 in26 cp5 21610.5996
RN5_26 in26 cn5 1000000
RP5_27 in27 cp5 155876.102
RN5_27 in27 cn5 1000000
RP5_28 in28 cp5 36699.2239
RN5_28 in28 cn5 1000000
RP5_29 in29 cp5 1000000
RN5_29 in29 cn5 55734.2406
RP5_30 in30 cp5 1000000
RN5_30 in30 cn5 32174.89
RP5_31 in31 cp5 1000000
RN5_31 in31 cn5 965973.543
RP5_32 in32 cp5 1000000
RN5_32 in32 cn5 1000000
RP5_33 in33 cp5 334313.952
RN5_33 in33 cn5 1000000
RP5_34 in34 cp5 56775.3971
RN5_34 in34 cn5 1000000
RP5_35 in35 cp5 1000000
RN5_35 in35 cn5 47381.1833
RP5_36 in36 cp5 1000000
RN5_36 in36 cn5 37651.8787
RP5_37 in37 cp5 107515.299
RN5_37 in37 cn5 1000000
RP5_38 in38 cp5 55648.8328
RN5_38 in38 cn5 1000000
RP5_39 in39 cp5 1000000
RN5_39 in39 cn5 1000000
RP5_40 in40 cp5 1000000
RN5_40 in40 cn5 989382.35
RP5_41 in41 cp5 1000000
RN5_41 in41 cn5 45229.9881
RP5_42 in42 cp5 1000000
RN5_42 in42 cn5 19554.1545
RP5_43 in43 cp5 1000000
RN5_43 in43 cn5 33208.4341
RP5_44 in44 cp5 1000000
RN5_44 in44 cn5 51734.4222
RP5_45 in45 cp5 65174.0277
RN5_45 in45 cn5 1000000
RP5_46 in46 cp5 131350.169
RN5_46 in46 cn5 1000000
RP5_47 in47 cp5 1000000
RN5_47 in47 cn5 875610.737
RP5_48 in48 cp5 1000000
RN5_48 in48 cn5 987166.003
RP5_49 in49 cp5 1000000
RN5_49 in49 cn5 318999.133
RP5_50 in50 cp5 1000000
RN5_50 in50 cn5 67241.2081
RP5_51 in51 cp5 1000000
RN5_51 in51 cn5 52436.4288
RP5_52 in52 cp5 112572.471
RN5_52 in52 cn5 1000000
RP5_53 in53 cp5 1000000
RN5_53 in53 cn5 204072.535
RP5_54 in54 cp5 1000000
RN5_54 in54 cn5 39061.3072
RP5_55 in55 cp5 1000000
RN5_55 in55 cn5 347503.671
RP5_56 in56 cp5 1000000
RN5_56 in56 cn5 998548.855
RP5_57 in57 cp5 95803.1292
RN5_57 in57 cn5 1000000
RP5_58 in58 cp5 16542.0497
RN5_58 in58 cn5 1000000
RP5_59 in59 cp5 30018.2236
RN5_59 in59 cn5 1000000
RP5_60 in60 cp5 1000000
RN5_60 in60 cn5 260499.565
RP5_61 in61 cp5 1000000
RN5_61 in61 cn5 37593.5495
RP5_62 in62 cp5 1000000
RN5_62 in62 cn5 37702.9262
RP5_63 in63 cp5 1000000
RN5_63 in63 cn5 122392.624
RP5_64 bias cp5 700243.648
RN5_64 bias cn5 1000000
RP6_0 in0 cp6 1000000
RN6_0 in0 cn6 1000000
RP6_1 in1 cp6 1000000
RN6_1 in1 cn6 278191.915
RP6_2 in2 cp6 1000000
RN6_2 in2 cn6 29464.8216
RP6_3 in3 cp6 1000000
RN6_3 in3 cn6 107505.173
RP6_4 in4 cp6 1000000
RN6_4 in4 cn6 134935.026
RP6_5 in5 cp6 1000000
RN6_5 in5 cn6 32828.564
RP6_6 in6 cp6 1000000
RN6_6 in6 cn6 139513.15
RP6_7 in7 cp6 1000000
RN6_7 in7 cn6 840743.159
RP6_8 in8 cp6 1000000
RN6_8 in8 cn6 982107.667
RP6_9 in9 cp6 1000000
RN6_9 in9 cn6 46582.722
RP6_10 in10 cp6 1000000
RN6_10 in10 cn6 42500.85
RP6_11 in11 cp6 167558.028
RN6_11 in11 cn6 1000000
RP6_12 in12 cp6 1000000
RN6_12 in12 cn6 24432.3851
RP6_13 in13 cp6 1000000
RN6_13 in13 cn6 20373.1608
RP6_14 in14 cp6 1000000
RN6_14 in14 cn6 123433.243
RP6_15 in15 cp6 1000000
RN6_15 in15 cn6 686078.631
RP6_16 in16 cp6 1000000
RN6_16 in16 cn6 999216.388
RP6_17 in17 cp6 1000000
RN6_17 in17 cn6 47443.725
RP6_18 in18 cp6 56964.0419
RN6_18 in18 cn6 1000000
RP6_19 in19 cp6 99392.3496
RN6_19 in19 cn6 1000000
RP6_20 in20 cp6 1000000
RN6_20 in20 cn6 19131.4018
RP6_21 in21 cp6 1000000
RN6_21 in21 cn6 13871.9424
RP6_22 in22 cp6 1000000
RN6_22 in22 cn6 67439.5473
RP6_23 in23 cp6 1000000
RN6_23 in23 cn6 695710.874
RP6_24 in24 cp6 1000000
RN6_24 in24 cn6 989111.188
RP6_25 in25 cp6 202321.454
RN6_25 in25 cn6 1000000
RP6_26 in26 cp6 56848.6134
RN6_26 in26 cn6 1000000
RP6_27 in27 cp6 171732.672
RN6_27 in27 cn6 1000000
RP6_28 in28 cp6 1000000
RN6_28 in28 cn6 47481.9702
RP6_29 in29 cp6 1000000
RN6_29 in29 cn6 45203.5337
RP6_30 in30 cp6 1000000
RN6_30 in30 cn6 37165.5293
RP6_31 in31 cp6 1000000
RN6_31 in31 cn6 938646.141
RP6_32 in32 cp6 1000000
RN6_32 in32 cn6 1000000
RP6_33 in33 cp6 52509.4942
RN6_33 in33 cn6 1000000
RP6_34 in34 cp6 24597.0882
RN6_34 in34 cn6 1000000
RP6_35 in35 cp6 35152.767
RN6_35 in35 cn6 1000000
RP6_36 in36 cp6 89878.1738
RN6_36 in36 cn6 1000000
RP6_37 in37 cp6 141900.847
RN6_37 in37 cn6 1000000
RP6_38 in38 cp6 266492.658
RN6_38 in38 cn6 1000000
RP6_39 in39 cp6 1000000
RN6_39 in39 cn6 1000000
RP6_40 in40 cp6 1000000
RN6_40 in40 cn6 786600.182
RP6_41 in41 cp6 1000000
RN6_41 in41 cn6 99996.904
RP6_42 in42 cp6 13893.8065
RN6_42 in42 cn6 1000000
RP6_43 in43 cp6 37597.8022
RN6_43 in43 cn6 1000000
RP6_44 in44 cp6 1000000
RN6_44 in44 cn6 255163.757
RP6_45 in45 cp6 72450.5489
RN6_45 in45 cn6 1000000
RP6_46 in46 cp6 25893.1301
RN6_46 in46 cn6 1000000
RP6_47 in47 cp6 437500.112
RN6_47 in47 cn6 1000000
RP6_48 in48 cp6 1000000
RN6_48 in48 cn6 695232.249
RP6_49 in49 cp6 1000000
RN6_49 in49 cn6 63271.0615
RP6_50 in50 cp6 42162.1311
RN6_50 in50 cn6 1000000
RP6_51 in51 cp6 34593.3633
RN6_51 in51 cn6 1000000
RP6_52 in52 cp6 1000000
RN6_52 in52 cn6 35434.1096
RP6_53 in53 cp6 26246.0449
RN6_53 in53 cn6 1000000
RP6_54 in54 cp6 26322.1268
RN6_54 in54 cn6 1000000
RP6_55 in55 cp6 1000000
RN6_55 in55 cn6 104878.462
RP6_56 in56 cp6 1000000
RN6_56 in56 cn6 998044.641
RP6_57 in57 cp6 1000000
RN6_57 in57 cn6 271195.621
RP6_58 in58 cp6 1000000
RN6_58 in58 cn6 32258.0897
RP6_59 in59 cp6 1000000
RN6_59 in59 cn6 63160.6034
RP6_60 in60 cp6 152326.094
RN6_60 in60 cn6 1000000
RP6_61 in61 cp6 20607.7323
RN6_61 in61 cn6 1000000
RP6_62 in62 cp6 181030.688
RN6_62 in62 cn6 1000000
RP6_63 in63 cp6 1000000
RN6_63 in63 cn6 88243.0797
RP6_64 bias cp6 1000000
RN6_64 bias cn6 161212.431
RP7_0 in0 cp7 1000000
RN7_0 in0 cn7 1000000
RP7_1 in1 cp7 399883.112
RN7_1 in1 cn7 1000000
RP7_2 in2 cp7 103435.071
RN7_2 in2 cn7 1000000
RP7_3 in3 cp7 49316.5356
RN7_3 in3 cn7 1000000
RP7_4 in4 cp7 39102.006
RN7_4 in4 cn7 1000000
RP7_5 in5 cp7 40930.9029
RN7_5 in5 cn7 1000000
RP7_6 in6 cp7 25056.7997
RN7_6 in6 cn7 1000000
RP7_7 in7 cp7 62180.6498
RN7_7 in7 cn7 1000000
RP7_8 in8 cp7 1000000
RN7_8 in8 cn7 986652.759
RP7_9 in9 cp7 363089.54
RN7_9 in9 cn7 1000000
RP7_10 in10 cp7 131345.285
RN7_10 in10 cn7 1000000
RP7_11 in11 cp7 64030.9001
RN7_11 in11 cn7 1000000
RP7_12 in12 cp7 19572.1185
RN7_12 in12 cn7 1000000
RP7_13 in13 cp7 101026.705
RN7_13 in13 cn7 1000000
RP7_14 in14 cp7 56328.7142
RN7_14 in14 cn7 1000000
RP7_15 in15 cp7 61220.5807
RN7_15 in15 cn7 1000000
RP7_16 in16 cp7 1000000
RN7_16 in16 cn7 997443.596
RP7_17 in17 cp7 1000000
RN7_17 in17 cn7 43557.8895
RP7_18 in18 cp7 1000000
RN7_18 in18 cn7 19383.0539
RP7_19 in19 cp7 1000000
RN7_19 in19 cn7 30135.4574
RP7_20 in20 cp7 205855.924
RN7_20 in20 cn7 1000000
RP7_21 in21 cp7 66562.7113
RN7_21 in21 cn7 1000000
RP7_22 in22 cp7 38542.4038
RN7_22 in22 cn7 1000000
RP7_23 in23 cp7 352984.427
RN7_23 in23 cn7 1000000
RP7_24 in24 cp7 1000000
RN7_24 in24 cn7 988585.715
RP7_25 in25 cp7 1000000
RN7_25 in25 cn7 36136.5468
RP7_26 in26 cp7 1000000
RN7_26 in26 cn7 45975.8032
RP7_27 in27 cp7 1000000
RN7_27 in27 cn7 23755.6101
RP7_28 in28 cp7 264646.262
RN7_28 in28 cn7 1000000
RP7_29 in29 cp7 23567.0026
RN7_29 in29 cn7 1000000
RP7_30 in30 cp7 30500.0369
RN7_30 in30 cn7 1000000
RP7_31 in31 cp7 1000000
RN7_31 in31 cn7 695586.624
RP7_32 in32 cp7 1000000
RN7_32 in32 cn7 1000000
RP7_33 in33 cp7 222917.177
RN7_33 in33 cn7 1000000
RP7_34 in34 cp7 149762.964
RN7_34 in34 cn7 1000000
RP7_35 in35 cp7 121359.851
RN7_35 in35 cn7 1000000
RP7_36 in36 cp7 41644.1482
RN7_36 in36 cn7 1000000
RP7_37 in37 cp7 22259.3106
RN7_37 in37 cn7 1000000
RP7_38 in38 cp7 34265.3511
RN7_38 in38 cn7 1000000
RP7_39 in39 cp7 1000000
RN7_39 in39 cn7 1000000
RP7_40 in40 cp7 1000000
RN7_40 in40 cn7 984091.449
RP7_41 in41 cp7 804131.251
RN7_41 in41 cn7 1000000
RP7_42 in42 cp7 901927.574
RN7_42 in42 cn7 1000000
RP7_43 in43 cp7 35615.1322
RN7_43 in43 cn7 1000000
RP7_44 in44 cp7 79086.9214
RN7_44 in44 cn7 1000000
RP7_45 in45 cp7 1000000
RN7_45 in45 cn7 153068.73
RP7_46 in46 cp7 1000000
RN7_46 in46 cn7 155598.723
RP7_47 in47 cp7 1000000
RN7_47 in47 cn7 964871.927
RP7_48 in48 cp7 1000000
RN7_48 in48 cn7 928847.89
RP7_49 in49 cp7 1000000
RN7_49 in49 cn7 147348.83
RP7_50 in50 cp7 1000000
RN7_50 in50 cn7 57223.6277
RP7_51 in51 cp7 57473.4531
RN7_51 in51 cn7 1000000
RP7_52 in52 cp7 1000000
RN7_52 in52 cn7 20401.8078
RP7_53 in53 cp7 1000000
RN7_53 in53 cn7 13901.7619
RP7_54 in54 cp7 1000000
RN7_54 in54 cn7 51716.5881
RP7_55 in55 cp7 1000000
RN7_55 in55 cn7 561551.608
RP7_56 in56 cp7 1000000
RN7_56 in56 cn7 982446.969
RP7_57 in57 cp7 1000000
RN7_57 in57 cn7 340505.928
RP7_58 in58 cp7 98682.0669
RN7_58 in58 cn7 1000000
RP7_59 in59 cp7 1000000
RN7_59 in59 cn7 53351.9086
RP7_60 in60 cp7 1000000
RN7_60 in60 cn7 13962.2325
RP7_61 in61 cp7 1000000
RN7_61 in61 cn7 18371.0695
RP7_62 in62 cp7 1000000
RN7_62 in62 cn7 72848.5026
RP7_63 in63 cp7 1000000
RN7_63 in63 cn7 401406.099
RP7_64 bias cp7 31040.2531
RN7_64 bias cn7 1000000
RP8_0 in0 cp8 1000000
RN8_0 in0 cn8 1000000
RP8_1 in1 cp8 1000000
RN8_1 in1 cn8 180641.781
RP8_2 in2 cp8 1000000
RN8_2 in2 cn8 120744.977
RP8_3 in3 cp8 1000000
RN8_3 in3 cn8 45413.5773
RP8_4 in4 cp8 220113.463
RN8_4 in4 cn8 1000000
RP8_5 in5 cp8 1000000
RN8_5 in5 cn8 603133.03
RP8_6 in6 cp8 1000000
RN8_6 in6 cn8 30571.3184
RP8_7 in7 cp8 1000000
RN8_7 in7 cn8 317605.913
RP8_8 in8 cp8 540045.906
RN8_8 in8 cn8 1000000
RP8_9 in9 cp8 1000000
RN8_9 in9 cn8 177804.655
RP8_10 in10 cp8 41631.2513
RN8_10 in10 cn8 1000000
RP8_11 in11 cp8 1000000
RN8_11 in11 cn8 53164.4113
RP8_12 in12 cp8 1000000
RN8_12 in12 cn8 31085.3004
RP8_13 in13 cp8 24720.1389
RN8_13 in13 cn8 1000000
RP8_14 in14 cp8 73301.3618
RN8_14 in14 cn8 1000000
RP8_15 in15 cp8 1000000
RN8_15 in15 cn8 376644.542
RP8_16 in16 cp8 1000000
RN8_16 in16 cn8 993391.753
RP8_17 in17 cp8 65488.5993
RN8_17 in17 cn8 1000000
RP8_18 in18 cp8 25481.3057
RN8_18 in18 cn8 1000000
RP8_19 in19 cp8 1000000
RN8_19 in19 cn8 427316.599
RP8_20 in20 cp8 1000000
RN8_20 in20 cn8 137099.742
RP8_21 in21 cp8 25139.2539
RN8_21 in21 cn8 1000000
RP8_22 in22 cp8 60276.98
RN8_22 in22 cn8 1000000
RP8_23 in23 cp8 1000000
RN8_23 in23 cn8 586167.319
RP8_24 in24 cp8 1000000
RN8_24 in24 cn8 985958.541
RP8_25 in25 cp8 1000000
RN8_25 in25 cn8 63572.6119
RP8_26 in26 cp8 1000000
RN8_26 in26 cn8 78929.5374
RP8_27 in27 cp8 16228.2447
RN8_27 in27 cn8 1000000
RP8_28 in28 cp8 181359.97
RN8_28 in28 cn8 1000000
RP8_29 in29 cp8 1000000
RN8_29 in29 cn8 182679.755
RP8_30 in30 cp8 1000000
RN8_30 in30 cn8 43514.7438
RP8_31 in31 cp8 1000000
RN8_31 in31 cn8 950989.742
RP8_32 in32 cp8 1000000
RN8_32 in32 cn8 1000000
RP8_33 in33 cp8 1000000
RN8_33 in33 cn8 34434.1389
RP8_34 in34 cp8 1000000
RN8_34 in34 cn8 63487.6067
RP8_35 in35 cp8 17919.2331
RN8_35 in35 cn8 1000000
RP8_36 in36 cp8 31288.5048
RN8_36 in36 cn8 1000000
RP8_37 in37 cp8 1000000
RN8_37 in37 cn8 19598.8534
RP8_38 in38 cp8 1000000
RN8_38 in38 cn8 19180.1835
RP8_39 in39 cp8 1000000
RN8_39 in39 cn8 1000000
RP8_40 in40 cp8 1000000
RN8_40 in40 cn8 985790.706
RP8_41 in41 cp8 1000000
RN8_41 in41 cn8 213164.186
RP8_42 in42 cp8 17165.3111
RN8_42 in42 cn8 1000000
RP8_43 in43 cp8 38616.277
RN8_43 in43 cn8 1000000
RP8_44 in44 cp8 47124.7561
RN8_44 in44 cn8 1000000
RP8_45 in45 cp8 30798.8619
RN8_45 in45 cn8 1000000
RP8_46 in46 cp8 1000000
RN8_46 in46 cn8 71780.5518
RP8_47 in47 cp8 1000000
RN8_47 in47 cn8 732582.568
RP8_48 in48 cp8 1000000
RN8_48 in48 cn8 708927.803
RP8_49 in49 cp8 224477.188
RN8_49 in49 cn8 1000000
RP8_50 in50 cp8 29978.8382
RN8_50 in50 cn8 1000000
RP8_51 in51 cp8 1000000
RN8_51 in51 cn8 20925.4664
RP8_52 in52 cp8 1000000
RN8_52 in52 cn8 23309.5156
RP8_53 in53 cp8 39012.5871
RN8_53 in53 cn8 1000000
RP8_54 in54 cp8 510373.289
RN8_54 in54 cn8 1000000
RP8_55 in55 cp8 1000000
RN8_55 in55 cn8 283094.823
RP8_56 in56 cp8 1000000
RN8_56 in56 cn8 884627.909
RP8_57 in57 cp8 1000000
RN8_57 in57 cn8 228516.789
RP8_58 in58 cp8 1000000
RN8_58 in58 cn8 22818.8258
RP8_59 in59 cp8 147063.133
RN8_59 in59 cn8 1000000
RP8_60 in60 cp8 23472.2871
RN8_60 in60 cn8 1000000
RP8_61 in61 cp8 1000000
RN8_61 in61 cn8 143304.877
RP8_62 in62 cp8 1000000
RN8_62 in62 cn8 57756.3393
RP8_63 in63 cp8 1000000
RN8_63 in63 cn8 133308.107
RP8_64 bias cp8 1000000
RN8_64 bias cn8 26614.5212
RP9_0 in0 cp9 1000000
RN9_0 in0 cn9 1000000
RP9_1 in1 cp9 1000000
RN9_1 in1 cn9 139410.189
RP9_2 in2 cp9 1000000
RN9_2 in2 cn9 111460.284
RP9_3 in3 cp9 32606.795
RN9_3 in3 cn9 1000000
RP9_4 in4 cp9 218641.512
RN9_4 in4 cn9 1000000
RP9_5 in5 cp9 1000000
RN9_5 in5 cn9 63299.0577
RP9_6 in6 cp9 202632.156
RN9_6 in6 cn9 1000000
RP9_7 in7 cp9 1000000
RN9_7 in7 cn9 248933.044
RP9_8 in8 cp9 1000000
RN9_8 in8 cn9 891383.11
RP9_9 in9 cp9 62414.3958
RN9_9 in9 cn9 1000000
RP9_10 in10 cp9 40944.377
RN9_10 in10 cn9 1000000
RP9_11 in11 cp9 156496.648
RN9_11 in11 cn9 1000000
RP9_12 in12 cp9 1000000
RN9_12 in12 cn9 75891.0358
RP9_13 in13 cp9 71750.9085
RN9_13 in13 cn9 1000000
RP9_14 in14 cp9 53278.413
RN9_14 in14 cn9 1000000
RP9_15 in15 cp9 1000000
RN9_15 in15 cn9 307924.355
RP9_16 in16 cp9 1000000
RN9_16 in16 cn9 969863.851
RP9_17 in17 cp9 78408.8825
RN9_17 in17 cn9 1000000
RP9_18 in18 cp9 31193.9571
RN9_18 in18 cn9 1000000
RP9_19 in19 cp9 286982.39
RN9_19 in19 cn9 1000000
RP9_20 in20 cp9 55708.7162
RN9_20 in20 cn9 1000000
RP9_21 in21 cp9 10073.7957
RN9_21 in21 cn9 1000000
RP9_22 in22 cp9 55605.5901
RN9_22 in22 cn9 1000000
RP9_23 in23 cp9 1000000
RN9_23 in23 cn9 399614.489
RP9_24 in24 cp9 1000000
RN9_24 in24 cn9 997467.28
RP9_25 in25 cp9 350919.302
RN9_25 in25 cn9 1000000
RP9_26 in26 cp9 29786.0801
RN9_26 in26 cn9 1000000
RP9_27 in27 cp9 16725.4581
RN9_27 in27 cn9 1000000
RP9_28 in28 cp9 30990.0344
RN9_28 in28 cn9 1000000
RP9_29 in29 cp9 18604.7464
RN9_29 in29 cn9 1000000
RP9_30 in30 cp9 53711.1726
RN9_30 in30 cn9 1000000
RP9_31 in31 cp9 1000000
RN9_31 in31 cn9 769767.871
RP9_32 in32 cp9 1000000
RN9_32 in32 cn9 1000000
RP9_33 in33 cp9 1000000
RN9_33 in33 cn9 26562.7619
RP9_34 in34 cp9 1000000
RN9_34 in34 cn9 42108.4158
RP9_35 in35 cp9 64808.6299
RN9_35 in35 cn9 1000000
RP9_36 in36 cp9 1000000
RN9_36 in36 cn9 22917.0987
RP9_37 in37 cp9 1000000
RN9_37 in37 cn9 264577.418
RP9_38 in38 cp9 265242.432
RN9_38 in38 cn9 1000000
RP9_39 in39 cp9 1000000
RN9_39 in39 cn9 1000000
RP9_40 in40 cp9 1000000
RN9_40 in40 cn9 998086.223
RP9_41 in41 cp9 1000000
RN9_41 in41 cn9 97123.0824
RP9_42 in42 cp9 1000000
RN9_42 in42 cn9 12873.1468
RP9_43 in43 cp9 1000000
RN9_43 in43 cn9 10000
RP9_44 in44 cp9 1000000
RN9_44 in44 cn9 20977.3075
RP9_45 in45 cp9 1000000
RN9_45 in45 cn9 38484.6551
RP9_46 in46 cp9 1000000
RN9_46 in46 cn9 711713.746
RP9_47 in47 cp9 1000000
RN9_47 in47 cn9 959080.77
RP9_48 in48 cp9 1000000
RN9_48 in48 cn9 990246.358
RP9_49 in49 cp9 114105.084
RN9_49 in49 cn9 1000000
RP9_50 in50 cp9 1000000
RN9_50 in50 cn9 47272.2848
RP9_51 in51 cp9 1000000
RN9_51 in51 cn9 26876.1392
RP9_52 in52 cp9 1000000
RN9_52 in52 cn9 42223.3
RP9_53 in53 cp9 1000000
RN9_53 in53 cn9 46769.9324
RP9_54 in54 cp9 102968.73
RN9_54 in54 cn9 1000000
RP9_55 in55 cp9 366336.451
RN9_55 in55 cn9 1000000
RP9_56 in56 cp9 1000000
RN9_56 in56 cn9 997799.889
RP9_57 in57 cp9 1000000
RN9_57 in57 cn9 141864.267
RP9_58 in58 cp9 185150.007
RN9_58 in58 cn9 1000000
RP9_59 in59 cp9 130285.645
RN9_59 in59 cn9 1000000
RP9_60 in60 cp9 82200.6095
RN9_60 in60 cn9 1000000
RP9_61 in61 cp9 1000000
RN9_61 in61 cn9 101591.983
RP9_62 in62 cp9 1000000
RN9_62 in62 cn9 264403.824
RP9_63 in63 cp9 1000000
RN9_63 in63 cn9 166543.07
RP9_64 bias cp9 1000000
RN9_64 bias cn9 39773.4296
* ---- neurons: two transimpedance amplifiers + one difference amplifier
XTP0 0 cp0 tp0 vcc vee OPA196 params: VOS=0
RFP0 cp0 tp0 5600
XTN0 0 cn0 tn0 vcc vee OPA196 params: VOS=0
RFN0 cn0 tn0 5600
RD1_0 tp0 dm0 100000
RD2_0 dm0 s0 100000
RD3_0 tn0 dp0 100000
RD4_0 dp0 0 100000
XD0 dp0 dm0 s0 vcc vee OPA196 params: VOS=0
CD2_0 dm0 s0 4.7e-12
CD4_0 dp0 0 4.7e-12
XTP1 0 cp1 tp1 vcc vee OPA196 params: VOS=0
RFP1 cp1 tp1 5600
XTN1 0 cn1 tn1 vcc vee OPA196 params: VOS=0
RFN1 cn1 tn1 5600
RD1_1 tp1 dm1 100000
RD2_1 dm1 s1 100000
RD3_1 tn1 dp1 100000
RD4_1 dp1 0 100000
XD1 dp1 dm1 s1 vcc vee OPA196 params: VOS=0
CD2_1 dm1 s1 4.7e-12
CD4_1 dp1 0 4.7e-12
XTP2 0 cp2 tp2 vcc vee OPA196 params: VOS=0
RFP2 cp2 tp2 5600
XTN2 0 cn2 tn2 vcc vee OPA196 params: VOS=0
RFN2 cn2 tn2 5600
RD1_2 tp2 dm2 100000
RD2_2 dm2 s2 100000
RD3_2 tn2 dp2 100000
RD4_2 dp2 0 100000
XD2 dp2 dm2 s2 vcc vee OPA196 params: VOS=0
CD2_2 dm2 s2 4.7e-12
CD4_2 dp2 0 4.7e-12
XTP3 0 cp3 tp3 vcc vee OPA196 params: VOS=0
RFP3 cp3 tp3 5600
XTN3 0 cn3 tn3 vcc vee OPA196 params: VOS=0
RFN3 cn3 tn3 5600
RD1_3 tp3 dm3 100000
RD2_3 dm3 s3 100000
RD3_3 tn3 dp3 100000
RD4_3 dp3 0 100000
XD3 dp3 dm3 s3 vcc vee OPA196 params: VOS=0
CD2_3 dm3 s3 4.7e-12
CD4_3 dp3 0 4.7e-12
XTP4 0 cp4 tp4 vcc vee OPA196 params: VOS=0
RFP4 cp4 tp4 5600
XTN4 0 cn4 tn4 vcc vee OPA196 params: VOS=0
RFN4 cn4 tn4 5600
RD1_4 tp4 dm4 100000
RD2_4 dm4 s4 100000
RD3_4 tn4 dp4 100000
RD4_4 dp4 0 100000
XD4 dp4 dm4 s4 vcc vee OPA196 params: VOS=0
CD2_4 dm4 s4 4.7e-12
CD4_4 dp4 0 4.7e-12
XTP5 0 cp5 tp5 vcc vee OPA196 params: VOS=0
RFP5 cp5 tp5 5600
XTN5 0 cn5 tn5 vcc vee OPA196 params: VOS=0
RFN5 cn5 tn5 5600
RD1_5 tp5 dm5 100000
RD2_5 dm5 s5 100000
RD3_5 tn5 dp5 100000
RD4_5 dp5 0 100000
XD5 dp5 dm5 s5 vcc vee OPA196 params: VOS=0
CD2_5 dm5 s5 4.7e-12
CD4_5 dp5 0 4.7e-12
XTP6 0 cp6 tp6 vcc vee OPA196 params: VOS=0
RFP6 cp6 tp6 5600
XTN6 0 cn6 tn6 vcc vee OPA196 params: VOS=0
RFN6 cn6 tn6 5600
RD1_6 tp6 dm6 100000
RD2_6 dm6 s6 100000
RD3_6 tn6 dp6 100000
RD4_6 dp6 0 100000
XD6 dp6 dm6 s6 vcc vee OPA196 params: VOS=0
CD2_6 dm6 s6 4.7e-12
CD4_6 dp6 0 4.7e-12
XTP7 0 cp7 tp7 vcc vee OPA196 params: VOS=0
RFP7 cp7 tp7 5600
XTN7 0 cn7 tn7 vcc vee OPA196 params: VOS=0
RFN7 cn7 tn7 5600
RD1_7 tp7 dm7 100000
RD2_7 dm7 s7 100000
RD3_7 tn7 dp7 100000
RD4_7 dp7 0 100000
XD7 dp7 dm7 s7 vcc vee OPA196 params: VOS=0
CD2_7 dm7 s7 4.7e-12
CD4_7 dp7 0 4.7e-12
XTP8 0 cp8 tp8 vcc vee OPA196 params: VOS=0
RFP8 cp8 tp8 5600
XTN8 0 cn8 tn8 vcc vee OPA196 params: VOS=0
RFN8 cn8 tn8 5600
RD1_8 tp8 dm8 100000
RD2_8 dm8 s8 100000
RD3_8 tn8 dp8 100000
RD4_8 dp8 0 100000
XD8 dp8 dm8 s8 vcc vee OPA196 params: VOS=0
CD2_8 dm8 s8 4.7e-12
CD4_8 dp8 0 4.7e-12
XTP9 0 cp9 tp9 vcc vee OPA196 params: VOS=0
RFP9 cp9 tp9 5600
XTN9 0 cn9 tn9 vcc vee OPA196 params: VOS=0
RFN9 cn9 tn9 5600
RD1_9 tp9 dm9 100000
RD2_9 dm9 s9 100000
RD3_9 tn9 dp9 100000
RD4_9 dp9 0 100000
XD9 dp9 dm9 s9 vcc vee OPA196 params: VOS=0
CD2_9 dm9 s9 4.7e-12
CD4_9 dp9 0 4.7e-12
.options method=gear
.control
set wr_singlescale
option numdgt=8
tran 20n 0.00012 0 20n
wrdata C:/Users/intel/Documents/NeuralSphere-V1/results/s07_transient_opa196.txt v(s0) v(s1) v(s2) v(s3) v(s4) v(s5) v(s6) v(s7) v(s8) v(s9) i(VCC) i(VEE) i(VB) i(VIN0) i(VIN1) i(VIN2) i(VIN3) i(VIN4) i(VIN5) i(VIN6) i(VIN7) i(VIN8) i(VIN9) i(VIN10) i(VIN11) i(VIN12) i(VIN13) i(VIN14) i(VIN15) i(VIN16) i(VIN17) i(VIN18) i(VIN19) i(VIN20) i(VIN21) i(VIN22) i(VIN23) i(VIN24) i(VIN25) i(VIN26) i(VIN27) i(VIN28) i(VIN29) i(VIN30) i(VIN31) i(VIN32) i(VIN33) i(VIN34) i(VIN35) i(VIN36) i(VIN37) i(VIN38) i(VIN39) i(VIN40) i(VIN41) i(VIN42) i(VIN43) i(VIN44) i(VIN45) i(VIN46) i(VIN47) i(VIN48) i(VIN49) i(VIN50) i(VIN51) i(VIN52) i(VIN53) i(VIN54) i(VIN55) i(VIN56) i(VIN57) i(VIN58) i(VIN59) i(VIN60) i(VIN61) i(VIN62) i(VIN63) v(in0) v(in1) v(in2) v(in3) v(in4) v(in5) v(in6) v(in7) v(in8) v(in9) v(in10) v(in11) v(in12) v(in13) v(in14) v(in15) v(in16) v(in17) v(in18) v(in19) v(in20) v(in21) v(in22) v(in23) v(in24) v(in25) v(in26) v(in27) v(in28) v(in29) v(in30) v(in31) v(in32) v(in33) v(in34) v(in35) v(in36) v(in37) v(in38) v(in39) v(in40) v(in41) v(in42) v(in43) v(in44) v(in45) v(in46) v(in47) v(in48) v(in49) v(in50) v(in51) v(in52) v(in53) v(in54) v(in55) v(in56) v(in57) v(in58) v(in59) v(in60) v(in61) v(in62) v(in63)
quit
.endc
.end
